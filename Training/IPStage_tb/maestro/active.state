ADE simulation setup
Test Training:IPStage_tb:1: Training/IPStage_tb/schematic, simulator spectre
  Models: /libs/UMC180_MM/UMC_18_CMOS/../Models/Spectre/mm180_bjt_v121.lib.scs[tt_bip], /libs/UMC180_MM/UMC_18_CMOS/../Models/Spectre/mm180_mimcap_v101.lib.scs[mimcaps_typ], /libs/UMC180_MM/UMC_18_CMOS/../Models/Spectre/mm180_reg18bpw_v123.lib.scs[tt], /libs/UMC180_MM/UMC_18_CMOS/../Models/Spectre/mm180_reg33bpw_v123.lib.scs[tt], /libs/UMC180_MM/UMC_18_CMOS/../Models/Spectre/mm180_res_v141.lib.scs[res_typ], /libs/UMC180_MM/UMC_18_CMOS/../Models/Spectre/mm180_lvt18_v113.lib.scs[tt], /libs/UMC180_MM/UMC_18_CMOS/../Models/Spectre/mm180_lvt33_v113.lib.scs[tt], /libs/UMC180_MM/UMC_18_CMOS/../Models/Spectre/mm180_reg18_v124.lib.scs[tt], /libs/UMC180_MM/UMC_18_CMOS/../Models/Spectre/mm180_reg33_v114.lib.scs[tt], /libs/UMC180_MM/UMC_18_CMOS/../Models/Spectre/mm180_zvt18_v121.lib.scs[tt], /libs/UMC180_MM/UMC_18_CMOS/../Models/Spectre/mm180_zvt33_v113.lib.scs[tt], /libs/UMC180_MM/UMC_18_CMOS/../Models/Spectre/core_rf_v2d4.lib.scs[tt], /libs/UMC180_MM/UMC_18_CMOS/../Models/Spectre/io_rf_v2d3.lib.scs[tt], /libs/UMC180_MM/UMC_18_CMOS/../Models/Spectre/l_slcr20k_rf_v2d3.lib.scs[typ], /libs/UMC180_MM/UMC_18_CMOS/../Models/Spectre/mimcapm_rf_v2d3.lib.scs[typ], /libs/UMC180_MM/UMC_18_CMOS/../Models/Spectre/pad_rf_v2d3.lib.scs[typ], /libs/UMC180_MM/UMC_18_CMOS/../Models/Spectre/rnhr_rf_v2d4.lib.scs[typ], /libs/UMC180_MM/UMC_18_CMOS/../Models/Spectre/rnnpo_rf_v2d4.lib.scs[typ], /libs/UMC180_MM/UMC_18_CMOS/../Models/Spectre/rnppo_rf_v2d4.lib.scs[typ], /libs/UMC180_MM/UMC_18_CMOS/../Models/Spectre/vardiop_rf_v2d3.lib.scs[typ], /libs/UMC180_MM/UMC_18_CMOS/../Models/Spectre/varmis_18_rf_v2d3.lib.scs[typ], /libs/UMC180_MM/UMC_18_CMOS/../Models/Spectre/mm180_diode_v113.mdl.scs
  Variables: VCM_sweep = 1.8
  Temperature: 27
  Analysis dc: sweep VCM_sweep start=0 stop=1.8
  Output (VDC("/out_p") - VDC("/out_n"))
  Signals: /out_p, /out_n
Run mode: Single Run, Sweeps and Corners
