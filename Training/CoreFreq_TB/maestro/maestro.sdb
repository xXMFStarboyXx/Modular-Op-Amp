ADE simulation setup
Run mode: Single Run, Sweeps and Corners
Tests:
  Training:CoreFreq_TB:1: Training/CoreFreq_TB/schematic, simulator spectre
    Outputs: /Out; dB20(VF("/Out")); phase(VF("/Out"))
