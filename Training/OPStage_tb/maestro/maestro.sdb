ADE simulation setup
Run mode: Single Run, Sweeps and Corners
Tests:
  Training:OPStage_tb:1: Training/OPStage_tb/schematic, simulator spectre
    Outputs: /out
