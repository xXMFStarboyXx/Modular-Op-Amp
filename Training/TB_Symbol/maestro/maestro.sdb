ADE simulation setup
Run mode: Single Run, Sweeps and Corners
Tests:
  Training:TB_Symbol:1: Training/TB_Symbol/schematic, simulator spectre
    Outputs: /OUT
