ADE simulation setup
Test Training:OPAMP_Mod_Sym_TB:1: Training/OPAMP_Mod_Sym_TB/schematic, simulator spectre
  Models: /libs/UMC180_MM/UMC_18_CMOS/../Models/Spectre/mm180_bjt_v121.lib.scs[tt_bip], /libs/UMC180_MM/UMC_18_CMOS/../Models/Spectre/mm180_mimcap_v101.lib.scs[mimcaps_typ], /libs/UMC180_MM/UMC_18_CMOS/../Models/Spectre/mm180_reg18bpw_v123.lib.scs[tt], /libs/UMC180_MM/UMC_18_CMOS/../Models/Spectre/mm180_reg33bpw_v123.lib.scs[tt], /libs/UMC180_MM/UMC_18_CMOS/../Models/Spectre/mm180_res_v141.lib.scs[res_typ], /libs/UMC180_MM/UMC_18_CMOS/../Models/Spectre/mm180_lvt18_v113.lib.scs[tt], /libs/UMC180_MM/UMC_18_CMOS/../Models/Spectre/mm180_lvt33_v113.lib.scs[tt], /libs/UMC180_MM/UMC_18_CMOS/../Models/Spectre/mm180_reg18_v124.lib.scs[tt], /libs/UMC180_MM/UMC_18_CMOS/../Models/Spectre/mm180_reg33_v114.lib.scs[tt], /libs/UMC180_MM/UMC_18_CMOS/../Models/Spectre/mm180_zvt18_v121.lib.scs[tt], /libs/UMC180_MM/UMC_18_CMOS/../Models/Spectre/mm180_zvt33_v113.lib.scs[tt], /libs/UMC180_MM/UMC_18_CMOS/../Models/Spectre/core_rf_v2d4.lib.scs[tt], /libs/UMC180_MM/UMC_18_CMOS/../Models/Spectre/io_rf_v2d3.lib.scs[tt], /libs/UMC180_MM/UMC_18_CMOS/../Models/Spectre/l_slcr20k_rf_v2d3.lib.scs[typ], /libs/UMC180_MM/UMC_18_CMOS/../Models/Spectre/mimcapm_rf_v2d3.lib.scs[typ], /libs/UMC180_MM/UMC_18_CMOS/../Models/Spectre/pad_rf_v2d3.lib.scs[typ], /libs/UMC180_MM/UMC_18_CMOS/../Models/Spectre/rnhr_rf_v2d4.lib.scs[typ], /libs/UMC180_MM/UMC_18_CMOS/../Models/Spectre/rnnpo_rf_v2d4.lib.scs[typ], /libs/UMC180_MM/UMC_18_CMOS/../Models/Spectre/rnppo_rf_v2d4.lib.scs[typ], /libs/UMC180_MM/UMC_18_CMOS/../Models/Spectre/vardiop_rf_v2d3.lib.scs[typ], /libs/UMC180_MM/UMC_18_CMOS/../Models/Spectre/varmis_18_rf_v2d3.lib.scs[typ], /libs/UMC180_MM/UMC_18_CMOS/../Models/Spectre/mm180_diode_v113.mdl.scs
  Temperature: 27
  Files: definitions /home/aditya/Desktop/Project/SMRT_OPAMP/include/OpampParam/OpampParam.vams
  Analysis tran: stop=12u errpreset=conservative skipdc=rampup additionalParams=rampuptime=100n
  Output (VT("/net7") - VT("/Out")) (unticked)
  Output (VT("/I0/net15") - VT("/I0/net14")) (unticked)
  Signals: /Out, /I0/Out (terminal), /I0/net14, /I0/net15, /I0/net19
Run mode: Single Run, Sweeps and Corners
