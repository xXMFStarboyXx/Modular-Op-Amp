ADE simulation setup
Run mode: Single Run, Sweeps and Corners
Tests:
  Training:PSRR_Mod_TB:1: Training/PSRR_Mod_TB/schematic, simulator spectre
    Outputs: /out_er
