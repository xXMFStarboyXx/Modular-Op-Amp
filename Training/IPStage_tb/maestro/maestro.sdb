ADE simulation setup
Run mode: Single Run, Sweeps and Corners
Tests:
  Training:IPStage_tb:1: Training/IPStage_tb/schematic, simulator spectre
    Variables: VCM_sweep = 1.8
    Outputs: (getData("/out_p" ?result "dcOp") - getData("/out_n" ?result "dcOp")); (VDC("/out_p") - VDC("/out_n")); /out_p; /out_n
