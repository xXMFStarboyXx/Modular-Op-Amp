ADE simulation setup
Run mode: Single Run, Sweeps and Corners
Tests:
  Training:OPAMP_Mod_Sym_TB:1: Training/OPAMP_Mod_Sym_TB/schematic, simulator spectre
    Outputs: /Out; /I0/Out; ((V "/net7") - (V "/out")); (VT("/I0/net15") - VT("/I0/net14")); (VT("/net7") - VT("/out")); (VT("/net7") - VT("/Out"))
