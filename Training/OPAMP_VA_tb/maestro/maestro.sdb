ADE simulation setup
Run mode: Single Run, Sweeps and Corners
Tests:
  Training:OPAMP_VA_tb:1: Training/OPAMP_VA_tb/schematic, simulator spectre
    Outputs: OUTPUT; INPUT
